*******************************************************************************
* CDL netlist
*
* Library : Training
* Top Cell Name: inv
* View Name: schematic
* Netlist created: 31.Mar.2020 17:43:54
*******************************************************************************

*.SCALE METER
*.GLOBAL vdd gnd

*******************************************************************************
* Library Name: Training
* Cell Name:    inv
* View Name:    schematic
*******************************************************************************

.SUBCKT inv a y wp=300n wn=200n lp=30n ln=30n
*.PININFO y:O a:I

M2 y a gnd gnd C5NNMOS w=200n l=30n m=1
MN1 y a gnd gnd C5NNMOS w=200n l=30n m=1
MP1 y a vdd vdd C5NPMOS w=300n l=30n m=1
.ENDS
