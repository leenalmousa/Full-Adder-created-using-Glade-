*******************************************************************************
* CDL netlist
*
* Library : Training
* Top Cell Name: XOR LAYOUT
* View Name: layout
* Netlist created: 04.Aug.2024 19:59:12
*******************************************************************************

*.SCALE METER
*.GLOBAL vdd gnd

*******************************************************************************
* Library Name: Training
* Cell Name:    XOR LAYOUT
* View Name:    layout
*******************************************************************************

.SUBCKT XOR LAYOUT

.ENDS
