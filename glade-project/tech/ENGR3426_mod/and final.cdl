*******************************************************************************
* CDL netlist
*
* Library : Training
* Top Cell Name: AND SCHEM
* View Name: schematic
* Netlist created: 06.Aug.2024 12:40:27
*******************************************************************************

*.SCALE METER
*.GLOBAL vdd gnd

*******************************************************************************
* Library Name: Training
* Cell Name:    AND SCHEM
* View Name:    schematic
*******************************************************************************

.SUBCKT AND SCHEM  B A Vdd out
*.PININFO B:I out:O A:I Vdd:B

M4 out n0 gnd gnd C5NNMOS w=200n l=30n m=1
M5 out n0 Vdd Vdd C5NPMOS w=1600n l=30n m=1
M2 n0 B n2 gnd C5NNMOS w=200n l=30n m=1
M3 n0 B Vdd Vdd C5NPMOS w=1600n l=30n m=1
M0 n0 A Vdd Vdd C5NPMOS w=1600n l=30n m=1
M1 n2 A gnd gnd C5NNMOS w=200n l=30n m=1
.ENDS
