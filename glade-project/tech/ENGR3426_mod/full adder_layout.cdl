*******************************************************************************
* CDL netlist
*
* Library : Training
* Top Cell Name: full adder
* View Name: layout
* Netlist created: 06.Aug.2024 10:10:40
*******************************************************************************

*.SCALE METER
*.GLOBAL vdd gnd

*******************************************************************************
* Library Name: Training
* Cell Name:    full adder
* View Name:    layout
*******************************************************************************

.SUBCKT full adder
*.PININFO :I

.ENDS
