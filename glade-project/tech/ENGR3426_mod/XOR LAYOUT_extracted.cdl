*******************************************************************************
* CDL netlist
*
* Library : Training
* Top Cell Name: XOR LAYOUT
* View Name: extracted
* Netlist created: 06.Aug.2024 13:11:07
*******************************************************************************

*.SCALE METER
*.GLOBAL vdd gnd

*******************************************************************************
* Library Name: Training
* Cell Name:    XOR LAYOUT
* View Name:    extracted
*******************************************************************************

.SUBCKT XOR LAYOUT
*.PININFO

M84 n2 n5 n9 n2 C5NPMOS w=1.615e-6 l=3e-8 as=9.4425e-14 ps=3.5e-6 ad=8.6425e-14 pd=3.48e-6
M81 gnd n1 n3 gnd C5NNMOS w=2e-7 l=3e-8 as=1.25e-14 ps=6.5e-7 ad=1.1e-14 pd=6.2e-7
M86 n6 n4 n10 n2 C5NPMOS w=1.615e-6 l=3e-8 as=8.6425e-14 ps=3.48e-6 ad=8.6425e-14 pd=3.48e-6
M85 n9 n1 n6 n2 C5NPMOS w=1.615e-6 l=3e-8 as=8.6425e-14 ps=3.48e-6 ad=9.4425e-14 pd=3.5e-6
M83 n6 n7 n3 gnd C5NNMOS w=2e-7 l=3e-8 as=1.25e-14 ps=6.5e-7 ad=1.1e-14 pd=6.2e-7
M82 n3 n4 n6 gnd C5NNMOS w=2e-7 l=3e-8 as=1.25e-14 ps=6.5e-7 ad=1.1e-14 pd=6.2e-7
M87 n10 n7 n2 n2 C5NPMOS w=1.615e-6 l=3e-8 as=1e-13 ps=3.45e-6 ad=8.6425e-14 pd=3.48e-6
M80 n3 n5 gnd gnd C5NNMOS w=2e-7 l=3e-8 as=1.25e-14 ps=6.5e-7 ad=1.1e-14 pd=6.2e-7
.ENDS
