*******************************************************************************
* CDL netlist
*
* Library : Training
* Top Cell Name: nor
* View Name: layout
* Netlist created: 04.Aug.2024 22:40:09
*******************************************************************************

*.SCALE METER
*.GLOBAL vdd gnd

*******************************************************************************
* Library Name: Training
* Cell Name:    nor
* View Name:    layout
*******************************************************************************

.SUBCKT nor

.ENDS
