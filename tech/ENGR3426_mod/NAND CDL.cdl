*******************************************************************************
* CDL netlist
*
* Library : Training
* Top Cell Name: NAND SCH
* View Name: schematic
* Netlist created: 06.Aug.2024 12:39:22
*******************************************************************************

*.SCALE METER
*.GLOBAL vdd gnd

*******************************************************************************
* Library Name: Training
* Cell Name:    NAND SCH
* View Name:    schematic
*******************************************************************************

.SUBCKT NAND SCH B A NAND
*.PININFO B:I NAND:O A:I

M4 NAND B vdd vdd C5NPMOS w=1600n l=30n m=1
M2 NAND A vdd vdd C5NPMOS w=1600n l=30n m=1
M1 n0 A gnd gnd C5NNMOS w=200n l=30n m=1
M0 NAND B n0 gnd C5NNMOS w=200n l=30n m=1
.ENDS
