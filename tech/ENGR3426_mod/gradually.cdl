*******************************************************************************
* CDL netlist
*
* Library : Training
* Top Cell Name: xor new
* View Name: schematic
* Netlist created: 06.Aug.2024 10:02:35
*******************************************************************************

*.SCALE METER
*.GLOBAL vdd gnd

*******************************************************************************
* Library Name: Training
* Cell Name:    xor new
* View Name:    schematic
*******************************************************************************

.SUBCKT xor new  B out A Vdd
*.PININFO B:I out:I A:I Vdd:B

M14 n8 B gnd gnd C5NNMOS w=200n l=30n m=1
M12 n6 A gnd gnd C5NNMOS w=200n l=30n m=1
M18 out n8 n7 gnd C5NNMOS w=200n l=30n m=1
M17 n7 n6 gnd gnd C5NNMOS w=200n l=30n m=1
M19 n5 A Vdd Vdd C5NPMOS w=1600n l=30n m=1
M9 out A n7 gnd C5NNMOS w=200n l=30n m=1
M11 n9 n6 Vdd Vdd C5NPMOS w=1600n l=30n m=1
M16 out B n9 Vdd C5NPMOS w=1600n l=30n m=1
M15 n8 B Vdd Vdd C5NPMOS w=1600n l=30n m=1
M8 out n8 n5 Vdd C5NPMOS w=1600n l=30n m=1
M13 n6 A Vdd Vdd C5NPMOS w=1600n l=30n m=1
M10 n7 B gnd gnd C5NNMOS w=200n l=30n m=1
.ENDS
