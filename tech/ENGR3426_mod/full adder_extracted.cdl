*******************************************************************************
* CDL netlist
*
* Library : Training
* Top Cell Name: full adder
* View Name: extracted
* Netlist created: 06.Aug.2024 19:19:13
*******************************************************************************

*.SCALE METER
*.GLOBAL vdd gnd

*******************************************************************************
* Library Name: Training
* Cell Name:    full adder
* View Name:    extracted
*******************************************************************************

.SUBCKT full adder
*.PININFO

M46 n7 n12 gnd gnd C5NNMOS w=2e-7 l=3e-8 as=1.5e-14 ps=5.5e-7 ad=1.5e-14 pd=5.5e-7
M58 n17 n2 n13 gnd C5NNMOS w=2e-7 l=3e-8 as=1.5e-14 ps=5.5e-7 ad=1.5e-14 pd=5.5e-7
M43 n5 n14 gnd gnd C5NNMOS w=2e-7 l=3e-8 as=1.5e-14 ps=5.5e-7 ad=1.5e-14 pd=5.5e-7
M66 n3 n14 n12 n3 C5NPMOS w=1.615e-6 l=3e-8 as=9.4425e-14 ps=3.5e-6 ad=8.6425e-14 pd=3.48e-6
M82 n4 n7 n25 n3 C5NPMOS w=1.6e-6 l=3e-8 as=1.76e-13 ps=3.42e-6 ad=1.84e-13 pd=3.43e-6
M60 n4 n15 gnd gnd C5NNMOS w=2e-7 l=3e-8 as=1.5e-14 ps=5.5e-7 ad=1.5e-14 pd=5.5e-7
M45 n12 n14 n19 gnd C5NNMOS w=2e-7 l=3e-8 as=1.5e-14 ps=5.5e-7 ad=1.5e-14 pd=5.5e-7
M78 n17 n8 n23 n3 C5NPMOS w=1.615e-6 l=3e-8 as=9.4425e-14 ps=3.5e-6 ad=8.6425e-14 pd=3.48e-6
M71 n3 n3 n22 n3 C5NPMOS w=1.615e-6 l=3e-8 as=8.6425e-14 ps=3.48e-6 ad=1e-13 pd=3.45e-6
M77 n23 n16 n3 n3 C5NPMOS w=1.615e-6 l=3e-8 as=8.6425e-14 ps=3.48e-6 ad=9.4425e-14 pd=3.5e-6
M73 n3 n8 n11 n3 C5NPMOS w=1.615e-6 l=3e-8 as=9.4425e-14 ps=3.5e-6 ad=8.6425e-14 pd=3.48e-6
M48 n9 n14 gnd gnd C5NNMOS w=2e-7 l=3e-8 as=1.5e-14 ps=5.5e-7 ad=1.5e-14 pd=5.5e-7
M55 n15 n11 gnd gnd C5NNMOS w=2e-7 l=3e-8 as=1.5e-14 ps=5.5e-7 ad=1.5e-14 pd=5.5e-7
M75 n2 n8 n3 n3 C5NPMOS w=1.615e-6 l=3e-8 as=1.2e-13 ps=3.35e-6 ad=1.2e-13 pd=3.35e-6
M49 n10 n5 n9 gnd C5NNMOS w=2e-7 l=3e-8 as=1.5e-14 ps=5.5e-7 ad=1.5e-14 pd=5.5e-7
M61 gnd n7 n4 gnd C5NNMOS w=2e-7 l=3e-8 as=1.5e-14 ps=5.5e-7 ad=1.5e-14 pd=5.5e-7
M53 n16 n10 gnd gnd C5NNMOS w=2e-7 l=3e-8 as=1.5e-14 ps=5.5e-7 ad=1.5e-14 pd=5.5e-7
M50 n9 n3 n10 gnd C5NNMOS w=2e-7 l=3e-8 as=1.5e-14 ps=5.5e-7 ad=1.5e-14 pd=5.5e-7
M51 n20 n10 gnd gnd C5NNMOS w=2e-7 l=3e-8 as=1.5e-14 ps=5.5e-7 ad=1.5e-14 pd=5.5e-7
M52 n11 n8 n20 gnd C5NNMOS w=2e-7 l=3e-8 as=1.5e-14 ps=5.5e-7 ad=1.5e-14 pd=5.5e-7
M74 n16 n10 n3 n3 C5NPMOS w=1.615e-6 l=3e-8 as=1.2e-13 ps=3.35e-6 ad=1.2e-13 pd=3.35e-6
M79 n24 n2 n17 n3 C5NPMOS w=1.615e-6 l=3e-8 as=8.6425e-14 ps=3.48e-6 ad=8.6425e-14 pd=3.48e-6
M69 n10 n14 n21 n3 C5NPMOS w=1.615e-6 l=3e-8 as=9.4425e-14 ps=3.5e-6 ad=8.6425e-14 pd=3.48e-6
M63 n6 n3 n3 n3 C5NPMOS w=1.615e-6 l=3e-8 as=1.2e-13 ps=3.35e-6 ad=1.2e-13 pd=3.35e-6
M47 gnd n6 n9 gnd C5NNMOS w=2e-7 l=3e-8 as=1.5e-14 ps=5.5e-7 ad=1.5e-14 pd=5.5e-7
M59 n13 n10 n17 gnd C5NNMOS w=2e-7 l=3e-8 as=1.5e-14 ps=5.5e-7 ad=1.5e-14 pd=5.5e-7
M67 n7 n12 n3 n3 C5NPMOS w=1.615e-6 l=3e-8 as=1.2e-13 ps=3.35e-6 ad=1.2e-13 pd=3.35e-6
M83 n18 n4 n3 n3 C5NPMOS w=1.615e-6 l=3e-8 as=1.2e-13 ps=3.35e-6 ad=1.2e-13 pd=3.35e-6
M56 gnd n16 n13 gnd C5NNMOS w=2e-7 l=3e-8 as=1.5e-14 ps=5.5e-7 ad=1.5e-14 pd=5.5e-7
M65 n12 n3 n3 n3 C5NPMOS w=1.615e-6 l=3e-8 as=8.6425e-14 ps=3.48e-6 ad=9.4425e-14 pd=3.5e-6
M54 n2 n8 gnd gnd C5NNMOS w=2e-7 l=3e-8 as=1.5e-14 ps=5.5e-7 ad=1.5e-14 pd=5.5e-7
M80 n3 n10 n24 n3 C5NPMOS w=1.615e-6 l=3e-8 as=8.6425e-14 ps=3.48e-6 ad=1e-13 pd=3.45e-6
M44 n19 n3 gnd gnd C5NNMOS w=2e-7 l=3e-8 as=1.5e-14 ps=5.5e-7 ad=1.5e-14 pd=5.5e-7
M76 n15 n11 n3 n3 C5NPMOS w=1.615e-6 l=3e-8 as=1.2e-13 ps=3.35e-6 ad=1.2e-13 pd=3.35e-6
M62 n18 n4 gnd gnd C5NNMOS w=2e-7 l=3e-8 as=1.5e-14 ps=5.5e-7 ad=1.5e-14 pd=5.5e-7
M57 n13 n8 gnd gnd C5NNMOS w=2e-7 l=3e-8 as=1.5e-14 ps=5.5e-7 ad=1.5e-14 pd=5.5e-7
M70 n22 n5 n10 n3 C5NPMOS w=1.615e-6 l=3e-8 as=8.6425e-14 ps=3.48e-6 ad=8.6425e-14 pd=3.48e-6
M81 n25 n15 n3 n3 C5NPMOS w=1.6e-6 l=3e-8 as=1.76e-13 ps=3.42e-6 ad=1.84e-13 pd=3.43e-6
M42 n6 n3 gnd gnd C5NNMOS w=2e-7 l=3e-8 as=1.5e-14 ps=5.5e-7 ad=1.5e-14 pd=5.5e-7
M68 n21 n6 n3 n3 C5NPMOS w=1.615e-6 l=3e-8 as=8.6425e-14 ps=3.48e-6 ad=9.4425e-14 pd=3.5e-6
M64 n5 n14 n3 n3 C5NPMOS w=1.615e-6 l=3e-8 as=1.2e-13 ps=3.35e-6 ad=1.2e-13 pd=3.35e-6
M72 n11 n10 n3 n3 C5NPMOS w=1.615e-6 l=3e-8 as=8.6425e-14 ps=3.48e-6 ad=9.4425e-14 pd=3.5e-6
.ENDS
