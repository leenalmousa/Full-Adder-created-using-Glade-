*******************************************************************************
* CDL netlist
*
* Library : Training
* Top Cell Name: XOR SCHEM
* View Name: schematic
* Netlist created: 04.Aug.2024 21:14:49
*******************************************************************************

*.SCALE METER
*.GLOBAL vdd gnd

*******************************************************************************
* Library Name: Training
* Cell Name:    XOR SCHEM
* View Name:    schematic
*******************************************************************************

.SUBCKT XOR SCHEM in1 in1bar Vdd in2 out in2bar
*.PININFO in1:I in1bar:I Vdd:B in2:I out:I in2bar:I

M6 out in2bar n3 Vdd C5NPMOS w=1600n l=30n m=1
M9 out in2 n6 Vdd C5NPMOS w=1600n l=30n m=1
M4 out in2bar n1 gnd C5NNMOS w=200n l=30n m=1
M7 n3 in1 Vdd Vdd C5NPMOS w=1600n l=30n m=1
M2 out in1 n1 gnd C5NNMOS w=200n l=30n m=1
M5 n1 in2 gnd gnd C5NNMOS w=200n l=30n m=1
M3 n1 in1bar gnd gnd C5NNMOS w=200n l=30n m=1
M8 n6 in1bar Vdd Vdd C5NPMOS w=1600n l=30n m=1
.ENDS
