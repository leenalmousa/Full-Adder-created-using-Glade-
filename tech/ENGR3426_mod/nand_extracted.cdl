*******************************************************************************
* CDL netlist
*
* Library : Training
* Top Cell Name: nand
* View Name: extracted
* Netlist created: 04.Aug.2024 21:57:17
*******************************************************************************

*.SCALE METER
*.GLOBAL vdd gnd

*******************************************************************************
* Library Name: Training
* Cell Name:    nand
* View Name:    extracted
*******************************************************************************

.SUBCKT nand

M3 n2 n1 n0 n0 C5NPMOS w=4e-7 l=3e-8 as=2.3e-14 ps=1.03e-6 ad=2.2e-14 pd=1.02e-6
M2 n0 n4 n2 n0 C5NPMOS w=4e-7 l=3e-8 as=2.3e-14 ps=1.03e-6 ad=2.2e-14 pd=1.02e-6
M1 n5 n1 n2 n3 C5NNMOS w=8e-7 l=3e-8 as=4.6e-14 ps=1.83e-6 ad=4.4e-14 pd=1.82e-6
M0 n3 n4 n5 n3 C5NNMOS w=8e-7 l=3e-8 as=4.6e-14 ps=1.83e-6 ad=4.4e-14 pd=1.82e-6
.ENDS
