*******************************************************************************
* CDL netlist
*
* Library : Training
* Top Cell Name: OR LAYOUT
* View Name: layout
* Netlist created: 05.Aug.2024 20:12:14
*******************************************************************************

*.SCALE METER
*.GLOBAL vdd gnd

*******************************************************************************
* Library Name: Training
* Cell Name:    OR LAYOUT
* View Name:    layout
*******************************************************************************

.SUBCKT OR LAYOUT

.ENDS
