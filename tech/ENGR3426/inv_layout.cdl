*******************************************************************************
* CDL netlist
*
* Library : Training
* Top Cell Name: inv
* View Name: layout
* Netlist created: 13.Apr.2020 07:23:56
*******************************************************************************

*.SCALE METER
*.GLOBAL vdd gnd

*******************************************************************************
* Library Name: Training
* Cell Name:    inv
* View Name:    layout
*******************************************************************************

.SUBCKT inv

.ENDS
