*******************************************************************************
* CDL netlist
*
* Library : Training
* Top Cell Name: inverter layout
* View Name: extracted
* Netlist created: 06.Aug.2024 10:11:54
*******************************************************************************

*.SCALE METER
*.GLOBAL vdd gnd

*******************************************************************************
* Library Name: Training
* Cell Name:    inverter layout
* View Name:    extracted
*******************************************************************************

.SUBCKT inverter layout

M84 n1 n3 n0 n1 C5NNMOS w=2e-7 l=3e-8 as=1.5e-14 ps=5.5e-7 ad=1.5e-14 pd=5.5e-7
M85 n2 n3 n0 n2 C5NPMOS w=1.615e-6 l=3e-8 as=1.2e-13 ps=3.35e-6 ad=1.2e-13 pd=3.35e-6
.ENDS
