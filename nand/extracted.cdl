*******************************************************************************
* CDL netlist
*
* Library : Training
* Top Cell Name: NAND LAYOUT
* View Name: extracted
* Netlist created: 06.Aug.2024 12:39:40
*******************************************************************************

*.SCALE METER
*.GLOBAL vdd gnd

*******************************************************************************
* Library Name: Training
* Cell Name:    NAND LAYOUT
* View Name:    extracted
*******************************************************************************

.SUBCKT NAND LAYOUT

M53 n3 n4 n0 n3 C5NPMOS w=1.615e-6 l=3e-8 as=1.2e-13 ps=3.35e-6 ad=1.2e-13 pd=3.35e-6
M51 n3 n5 n4 n3 C5NPMOS w=1.615e-6 l=3e-8 as=9.4425e-14 ps=3.5e-6 ad=8.6425e-14 pd=3.48e-6
M50 n1 n4 n0 n1 C5NNMOS w=2e-7 l=3e-8 as=1.5e-14 ps=5.5e-7 ad=1.5e-14 pd=5.5e-7
M48 n1 n5 n7 n1 C5NNMOS w=2e-7 l=3e-8 as=1.5e-14 ps=5.5e-7 ad=1.5e-14 pd=5.5e-7
M49 n7 n2 n4 n1 C5NNMOS w=2e-7 l=3e-8 as=1.5e-14 ps=5.5e-7 ad=1.5e-14 pd=5.5e-7
M52 n4 n2 n3 n3 C5NPMOS w=1.615e-6 l=3e-8 as=8.8e-14 ps=3.42e-6 ad=9.4425e-14 pd=3.5e-6
.ENDS
