*******************************************************************************
* CDL netlist
*
* Library : Training
* Top Cell Name: NOR LAYOUT NEW
* View Name: extracted
* Netlist created: 04.Aug.2024 21:42:15
*******************************************************************************

*.SCALE METER
*.GLOBAL vdd gnd

*******************************************************************************
* Library Name: Training
* Cell Name:    NOR LAYOUT NEW
* View Name:    extracted
*******************************************************************************

.SUBCKT NOR LAYOUT NEW

M21 n2 n0 n4 n4 C5NNMOS w=2e-7 l=3e-8 as=1.25e-14 ps=6.5e-7 ad=1.1e-14 pd=6.2e-7
M24 n6 n0 n2 n1 C5NPMOS w=1.615e-6 l=3e-8 as=1e-13 ps=3.45e-6 ad=8.6425e-14 pd=3.48e-6
M23 n1 n3 n6 n1 C5NPMOS w=1.615e-6 l=3e-8 as=8.6425e-14 ps=3.48e-6 ad=8.6425e-14 pd=3.48e-6
M22 n1 n7  n1 C5NPMOS w=8e-7 l=5e-9
M20 n4 n3 n2 n4 C5NNMOS w=2e-7 l=3e-8 as=1.25e-14 ps=6.5e-7 ad=1.1e-14 pd=6.2e-7
.ENDS
