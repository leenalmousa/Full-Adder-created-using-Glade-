*******************************************************************************
* CDL netlist
*
* Library : Training
* Top Cell Name: OR SCHEM
* View Name: schematic
* Netlist created: 06.Aug.2024 12:48:14
*******************************************************************************

*.SCALE METER
*.GLOBAL vdd gnd

*******************************************************************************
* Library Name: Training
* Cell Name:    OR SCHEM
* View Name:    schematic
*******************************************************************************

.SUBCKT OR SCHEM B Vdd A out
*.PININFO B:I Vdd:B out:O A:I

M4 out n1 gnd gnd C5NNMOS w=200n l=30n m=1
M5_13 n3 A Vdd Vdd C5NPMOS w=1600n l=30n m=1
M5 out n1 Vdd Vdd C5NPMOS w=1600n l=30n m=1
M2 n1 B gnd gnd C5NNMOS w=200n l=30n m=1
M5_12 n1 B n3 Vdd C5NPMOS w=1600n l=30n m=1
M1 n1 A gnd gnd C5NNMOS w=200n l=30n m=1
.ENDS
