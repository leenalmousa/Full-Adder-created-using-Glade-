*******************************************************************************
* CDL netlist
*
* Library : Training
* Top Cell Name: AND layout
* View Name: layout
* Netlist created: 05.Aug.2024 09:41:33
*******************************************************************************

*.SCALE METER
*.GLOBAL vdd gnd

*******************************************************************************
* Library Name: Training
* Cell Name:    AND layout
* View Name:    layout
*******************************************************************************

.SUBCKT AND layout

.ENDS
